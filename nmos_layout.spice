* NGSPICE file created from nmos_layout.ext - technology: sky130A

.subckt nmos_layout
X0 a_110_0# a_90_n20# a_0_0# SUB sky130_fd_pr__nfet_01v8 ad=0.9 pd=3.8 as=0.9 ps=3.8 w=1 l=0.2
.ends
